* CNM25 PMOS subcircuit (extracted-view netlist model)
* Actual BSIM3 model parameters: see ../models/cnm25mod.lib
.subckt cnm25modp D G S B
.param w=4.5u l=3u
mp D G S B cnm25modp w={w} l={l}
.ends
